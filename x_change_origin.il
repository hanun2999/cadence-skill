axlCmdRegister( "co" 'Change_Origin ?cmdType "interactive")
defun( Change_Origin ()
let((p)
	axlMsgPut("Please Pick a point:")
	axlSingleSelectPoint()
	p = axlGetLastEnterPoint()
	axlDBChangeDesignOrigin(list(minus(xCoord(p)) minus(yCoord(p))))
	axlMsgPut(sprintf(nil "Design Origin Move to %L" p))
))
