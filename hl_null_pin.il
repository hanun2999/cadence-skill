axlCmdRegister( "hl_null_pin" 'hl_null_pin)

defun( hl_null_pin ()
let((all p)
	axlClearSelSet()
	axlVisibleDesign( nil)
	axlVisibleLayer( "PIN/TOP" t)
	axlVisibleLayer( "PIN/BOTTOM" t)
	axlVisibleUpdate(t)
	axlSetFindFilter( ?enabled list("noall" "pins") ?onButtons list("noall" "pins"))
	axlAddSelectAll()
	all= axlGetSelSet()
	foreach( p all
		axlDehighlightObject(p t)
		when(p -> net -> name == "" axlHighlightObject(p t))
	)
	axlClearSelSet()
))
