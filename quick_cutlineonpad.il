/*
├─
│ ├─        程序名称： quick_cutlineonpad.il
│ ├─        程序功能：自动删除所有位于焊盘上的丝印
│ ├─        创建时间：2014年08月15日
│ ├─        作    者：kevin wong
│ ├─        Q      Q：263350809
├─

*/
axlCmdRegister("quick_textset" 'quick_cutlineonpad)

;get the old layer display,for recover

defun( quick_cutlineonpad ()
let( ()

    ))
